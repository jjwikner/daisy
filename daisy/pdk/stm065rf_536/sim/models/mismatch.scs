// $Id: mismatch.scs,v 1.1 2008/03/24 12:55:00 dkfe1 Exp $
//----------------------------------------------------------------------
// (C) Copyright STMicroelectronics(2008)
//      Unauthorized Reproduction and Communication Strictly Prohibited.
// ----------------------------------------------------------------------
// TEMPLATE   : mismatch.t.rca 1.1 Fri Feb 16 15:51:51 2007
// PARAMETERS : final_lib.dds
// TRANSLATOR : dds 2.10.2 ("ddspp.tcl,v 1.77 2007/02/16 09:10:47" )
// Translated by dkfe1 on March 24, 2008
// PACKAGE    : "processPackage.tcl,v 1.50 2007/10/04 08:40:22"
// PACKAGE    : "util.tcl.rca 1.4 Mon Dec 17 18:41:32 2007"
// ----------------------------------------------------------------------

library mismatch

section no
parameters  diodelp_dev = 0
parameters  diodegp_dev = 0
parameters  diode25_dev = 0
parameters  diode18_dev = 0
parameters  diodeiso_dev = 0
parameters  dgnsvt25_dev = 0
parameters  dgpsvt25_dev = 0
parameters  dgnsvt18_dev = 0
parameters  dgpsvt18_dev = 0
parameters  svtlp_dev = 0
parameters  svtgp_dev = 0
parameters  lvtgp_dev = 0
parameters  lvtlp_dev = 0
parameters  hvtlp_dev = 0
parameters  hvtgp_dev = 0
parameters  sramdphvtlp_dev = 0
parameters  sramdpsvtlp_dev = 0
parameters  sramdpsvtgp_dev = 0
parameters  sramsphvtlp_dev = 0
parameters  sramspsvtlp_dev = 0
parameters  sramspsvtgp_dev = 0
parameters  svt18_dev = 0
parameters  svt25_dev = 0
parameters  svt25dram_dev = 0
parameters  dr25_dev = 0
parameters  dr18otp_dev = 0
parameters  dr25otp_dev = 0
parameters  npnv_dev = 0
parameters  pnpv_dev = 0
parameters  rpdiff_dev = 0
parameters  rpolys_dev = 0
parameters  rpolyn_dev = 0
parameters  rpolyp_dev = 0
parameters  rpolyh_dev = 0
parameters  rmetal_dev = 0
parameters  cpolyn25_dev = 0
parameters  cpolyp25_dev = 0
parameters  cpolynlp_dev = 0
parameters  cpolyplp_dev = 0
parameters  cpolyn18_dev = 0
parameters  cpolyp18_dev = 0
parameters  cfringe_dev = 0
parameters  cfringelem_dev = 0
parameters  cplate_dev = 0
parameters  cstrip_dev = 0
parameters  rpolyni_dev = 0
parameters  rpolypi_dev = 0
parameters  hpalp_dev = 0
parameters  ind_la_7m4x0y2z_dev = 0
parameters  ind_lonw_7m4x0y2z_dev = 0
parameters  ind_lomf_7m4x0y2z_dev = 0
parameters  ind_nw_7m4x0y2z_dev = 0
parameters  ind_pat_7m4x0y2z_dev = 0
parameters  cpo25nw_var_dev = 0
parameters  cpo25pw_var_dev = 0
parameters  cpo18nw_var_dev = 0
parameters  cpo18pw_var_dev = 0
parameters  cpo12nw_var_dev = 0
parameters  var_pnw_dev = 0
parameters  cmom_dev = 0
parameters  mtpcell_dev = 0
parameters  cmim5_dev = 0
parameters  cmim_dev = 0
parameters  ext18hv_dev = 0
parameters  schottky_dev = 0
parameters  cmetal_dev = 0
endsection no
section mc
parameters  diodelp_dev = 1
parameters  diodegp_dev = 1
parameters  diode25_dev = 1
parameters  diode18_dev = 1
parameters  diodeiso_dev = 1
parameters  dgnsvt25_dev = 1
parameters  dgpsvt25_dev = 1
parameters  dgnsvt18_dev = 1
parameters  dgpsvt18_dev = 1
parameters  svtlp_dev = 1
parameters  svtgp_dev = 1
parameters  lvtgp_dev = 1
parameters  lvtlp_dev = 1
parameters  hvtlp_dev = 1
parameters  hvtgp_dev = 1
parameters  sramdphvtlp_dev = 1
parameters  sramdpsvtlp_dev = 1
parameters  sramdpsvtgp_dev = 1
parameters  sramsphvtlp_dev = 1
parameters  sramspsvtlp_dev = 1
parameters  sramspsvtgp_dev = 1
parameters  svt18_dev = 1
parameters  svt25_dev = 1
parameters  svt25dram_dev = 1
parameters  dr25_dev = 1
parameters  dr18otp_dev = 1
parameters  dr25otp_dev = 1
parameters  npnv_dev = 1
parameters  pnpv_dev = 1
parameters  rpdiff_dev = 1
parameters  rpolys_dev = 1
parameters  rpolyn_dev = 1
parameters  rpolyp_dev = 1
parameters  rpolyh_dev = 1
parameters  rmetal_dev = 1
parameters  cpolyn25_dev = 1
parameters  cpolyp25_dev = 1
parameters  cpolynlp_dev = 1
parameters  cpolyplp_dev = 1
parameters  cpolyn18_dev = 1
parameters  cpolyp18_dev = 1
parameters  cfringe_dev = 1
parameters  cfringelem_dev = 1
parameters  cplate_dev = 1
parameters  cstrip_dev = 1
parameters  rpolyni_dev = 1
parameters  rpolypi_dev = 1
parameters  hpalp_dev = 1
parameters  ind_la_7m4x0y2z_dev = 1
parameters  ind_lonw_7m4x0y2z_dev = 1
parameters  ind_lomf_7m4x0y2z_dev = 1
parameters  ind_nw_7m4x0y2z_dev = 1
parameters  ind_pat_7m4x0y2z_dev = 1
parameters  cpo25nw_var_dev = 1
parameters  cpo25pw_var_dev = 1
parameters  cpo18nw_var_dev = 1
parameters  cpo18pw_var_dev = 1
parameters  cpo12nw_var_dev = 1
parameters  var_pnw_dev = 1
parameters  cmom_dev = 1
parameters  mtpcell_dev = 1
parameters  cmim5_dev = 1
parameters  cmim_dev = 1
parameters  ext18hv_dev = 1
parameters  schottky_dev = 1
parameters  cmetal_dev = 1
endsection mc
section corner
parameters  diodelp_dev = 0
parameters  diodegp_dev = 0
parameters  diode25_dev = 0
parameters  diode18_dev = 0
parameters  diodeiso_dev = 0
parameters  dgnsvt25_dev = 0
parameters  dgpsvt25_dev = 0
parameters  dgnsvt18_dev = 0
parameters  dgpsvt18_dev = 0
parameters  svtlp_dev = 2
parameters  svtgp_dev = 2
parameters  lvtgp_dev = 2
parameters  lvtlp_dev = 2
parameters  hvtlp_dev = 2
parameters  hvtgp_dev = 2
parameters  sramdphvtlp_dev = 2
parameters  sramdpsvtlp_dev = 2
parameters  sramdpsvtgp_dev = 2
parameters  sramsphvtlp_dev = 2
parameters  sramspsvtlp_dev = 2
parameters  sramspsvtgp_dev = 2
parameters  svt18_dev = 2
parameters  svt25_dev = 2
parameters  svt25dram_dev = 2
parameters  dr25_dev = 2
parameters  dr18otp_dev = 2
parameters  dr25otp_dev = 2
parameters  npnv_dev = 0
parameters  pnpv_dev = 0
parameters  rpdiff_dev = 2
parameters  rpolys_dev = 2
parameters  rpolyn_dev = 2
parameters  rpolyp_dev = 2
parameters  rpolyh_dev = 2
parameters  rmetal_dev = 0
parameters  cpolyn25_dev = 0
parameters  cpolyp25_dev = 0
parameters  cpolynlp_dev = 0
parameters  cpolyplp_dev = 0
parameters  cpolyn18_dev = 0
parameters  cpolyp18_dev = 0
parameters  cfringe_dev = 0
parameters  cfringelem_dev = 0
parameters  cplate_dev = 0
parameters  cstrip_dev = 0
parameters  rpolyni_dev = 0
parameters  rpolypi_dev = 0
parameters  hpalp_dev = 2
parameters  ind_la_7m4x0y2z_dev = 0
parameters  ind_lonw_7m4x0y2z_dev = 0
parameters  ind_lomf_7m4x0y2z_dev = 0
parameters  ind_nw_7m4x0y2z_dev = 0
parameters  ind_pat_7m4x0y2z_dev = 0
parameters  cpo25nw_var_dev = 0
parameters  cpo25pw_var_dev = 0
parameters  cpo18nw_var_dev = 0
parameters  cpo18pw_var_dev = 0
parameters  cpo12nw_var_dev = 0
parameters  var_pnw_dev = 0
parameters  cmom_dev = 2
parameters  mtpcell_dev = 0
parameters  cmim5_dev = 2
parameters  cmim_dev = 0
parameters  ext18hv_dev = 2
parameters  schottky_dev = 0
parameters  cmetal_dev = 2
endsection corner
section param
parameters  diodelp_dev = 0
parameters  diodegp_dev = 0
parameters  diode25_dev = 0
parameters  diode18_dev = 0
parameters  diodeiso_dev = 0
parameters  dgnsvt25_dev = 0
parameters  dgpsvt25_dev = 0
parameters  dgnsvt18_dev = 0
parameters  dgpsvt18_dev = 0
parameters  svtlp_dev = 3
parameters  svtgp_dev = 3
parameters  lvtgp_dev = 3
parameters  lvtlp_dev = 3
parameters  hvtlp_dev = 3
parameters  hvtgp_dev = 3
parameters  sramdphvtlp_dev = 3
parameters  sramdpsvtlp_dev = 3
parameters  sramdpsvtgp_dev = 3
parameters  sramsphvtlp_dev = 3
parameters  sramspsvtlp_dev = 3
parameters  sramspsvtgp_dev = 3
parameters  svt18_dev = 3
parameters  svt25_dev = 3
parameters  svt25dram_dev = 3
parameters  dr25_dev = 3
parameters  dr18otp_dev = 3
parameters  dr25otp_dev = 3
parameters  npnv_dev = 0
parameters  pnpv_dev = 0
parameters  rpdiff_dev = 3
parameters  rpolys_dev = 3
parameters  rpolyn_dev = 3
parameters  rpolyp_dev = 3
parameters  rpolyh_dev = 3
parameters  rmetal_dev = 0
parameters  cpolyn25_dev = 0
parameters  cpolyp25_dev = 0
parameters  cpolynlp_dev = 0
parameters  cpolyplp_dev = 0
parameters  cpolyn18_dev = 0
parameters  cpolyp18_dev = 0
parameters  cfringe_dev = 0
parameters  cfringelem_dev = 0
parameters  cplate_dev = 0
parameters  cstrip_dev = 0
parameters  rpolyni_dev = 0
parameters  rpolypi_dev = 0
parameters  hpalp_dev = 3
parameters  ind_la_7m4x0y2z_dev = 0
parameters  ind_lonw_7m4x0y2z_dev = 0
parameters  ind_lomf_7m4x0y2z_dev = 0
parameters  ind_nw_7m4x0y2z_dev = 0
parameters  ind_pat_7m4x0y2z_dev = 0
parameters  cpo25nw_var_dev = 0
parameters  cpo25pw_var_dev = 0
parameters  cpo18nw_var_dev = 0
parameters  cpo18pw_var_dev = 0
parameters  cpo12nw_var_dev = 0
parameters  var_pnw_dev = 0
parameters  cmom_dev = 3
parameters  mtpcell_dev = 0
parameters  cmim5_dev = 3
parameters  cmim_dev = 0
parameters  ext18hv_dev = 3
parameters  schottky_dev = 0
parameters  cmetal_dev = 3
endsection param

endlibrary mismatch
