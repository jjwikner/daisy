ADE simulation setup
Run mode: Monte Carlo Sampling
Tests:
  daisyDemo:daisyDemoPpar_T:1: daisyDemo/daisyDemoPpar_T/schematic, simulator spectre
Global variables:
  cLoad = 1p
  vInDc = 1
  daisyRes = 1k
  daisyRes2 = daisyRes
  daisyRes1 = daisyRes
Monte Carlo Sampling options: mcmethod=all, mcnumpoints=3
